# Ansys Electronics Desktop project, version 2024.2
materials:
  vacuum: permittivity=1
  Rogers RT/duroid 5880 (tm): permittivity=2.2 dielectric_loss_tangent=0.0009
  copper: permeability=0.999991 conductivity=58000000
  pec: conductivity=1e+30
  Material1

design HFSSDesign1 (HFSS, HFSS Modal Network, model units mm)
options: Save_Adaptive_support_files
geometry:
  Polyline1 = polyline((0.4mm, -1.8mm, 0mm) (0.4mm, -1mm, 0mm))
  Polyline2 = polyline((0.4mm, -1.8mm, 0mm) (0.5mm, -1.8mm, 0mm))
  Polyline3 = polyline((0.5mm, -1.8mm, 0mm) (0.5mm, -1mm, 0mm))
  Polyline4 = polyline(z=0mm, xy in mm: (0.4, -1) (0.2, -0.4) (-0.2, 0), Arc from point 0 over 3)
  Polyline5 = polyline(z=0mm, xy in mm: (0.5, -1) (0.4, 0) (-0.2, 1), Arc from point 0 over 3)
  Polyline6 = polyline((-0.2mm, 0mm, 0mm) (-0.2mm, 1mm, 0mm))
  Polyline1.unite(Polyline2..Polyline6)
  Polyline1.cover_lines()
  Box1 [Rogers RT/duroid 5880 (tm)] = box(corner=(0.5mm, -1.8mm, 0mm), size=(1.3mm, 2.8mm, -0.1mm))
  top [copper] = Polyline1.duplicate_along_line(step=(0.7mm, 0mm, 0mm), total=2)
  Polyline1.delete()
  Polyline1_1_1 = top.duplicate_mirror(point=(2.2mm, -1.8mm, 0mm), normal=(1mm, 0mm, 0mm))
  bottom [copper] = Polyline1_1_1.duplicate_along_line(step=(-2.1mm, 0mm, -0.1mm), total=2)
  Polyline1_1_1.delete()
  Polyline7 = polyline(z=-0.1mm, xy in mm: (1.1, -1.4) (1, -1.6) (0.825, -1.8), Arc from point 0 over 3)
  Polyline8 = polyline(z=-0.1mm, xy in mm: (1.2, -1.4) (1.3, -1.6) (1.475, -1.8) (1.2, -1.8), covered, Arc from point 0 over 3)
  Polyline9 = polyline(z=-0.1mm, xy in mm: (0.825, -1.8) (1.1, -1.8) (1.1, -1.4))
  Polyline7.unite(Polyline9)
  Polyline7.cover_lines()
  Polyline10 = polyline(z=-0.1mm, xy in mm: (1.2, -1.4) (1.2, -1.8) (1.475, -1.8))
  Polyline8.unite(Polyline10)
  Polyline8.cover_lines()
  bottom.unite(Polyline8, Polyline7)
  Rectangle1 = rectangle(corner=(0.8mm, -1.8mm, 0mm), z_size=-0.1mm, x_size=0.7mm)
  Box2 [vacuum] = box(corner=(-0.2mm, -2.2mm, -0.85mm), size=(2.8mm, 3.5mm, 1.5mm))
  [Box1, Box2, Rectangle1, bottom, top].scale(2, 2, 2)
  [Box1, Box2, bottom, top, Rectangle1].scale(10, 10, 10)
  coordinate_system RelativeCS1 = origin=(22mm, 8mm, 0mm) x=(2mm, 0mm, 0mm) y=(0mm, 1mm, 0mm)
  coordinate_system RelativeCS2 = origin=(4mm, 4mm, 0mm) x=(1mm, 0mm, 0mm) y=(0mm, 1mm, 0mm) in RelativeCS1
  top.thicken(0.035mm)
  bottom.thicken(-0.035mm)
boundaries and excitations:
  PerfE1: Perfect E Objects=[bottom, top]
  Rad1: Radiation Objects=Box2
  1: Lumped Port Objects=Rectangle1 LumpedPortType=Modal Modes{Mode1{IntLine{(24.076923, -36, -2) -> (24.076923, -36, 0)} CharImp=Zpi RenormImp=50ohm}} Impedance=50ohm
setups:
  Setup1: HfssDriven MultipleAdaptiveFreqsSetup{Low=8GHz High=14GHz} MaxDeltaS=0.02 MaximumPasses=20 MinimumPasses=1 MinimumConvergedPasses=1 PercentRefinement=30 BasisOrder=1 PortAccuracy=2 DrivenSolverType="Direct Solver"
    sweep Sweep1: 8GHz to 15GHz step 0.1GHz; Type=Fast SaveFields
source amplitudes:
  1:1: 1W 0deg
radiation setups:
  Infinite Sphere1: Infinite Sphere Theta=-180deg..180deg step 3deg Phi=0deg..90deg step 90deg
reports:
  S Parameter Plot 1: dB(S(1,1)) vs Freq on Setup1 : Sweep1; markers m2 at 10.8GHz
  Gain Plot 1: dB(GainTotal) vs Theta on Setup1 : LastAdaptive, Infinite Sphere1 [Phi=0deg,90deg Freq=11GHz]
